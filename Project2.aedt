# Ansys Electronics Desktop project, version 2021.1
materials:
  vacuum: permittivity=1
  PVC plastic: permittivity=2.7 dielectric_loss_tangent=0.007
  graphite: conductivity=70000
  copper: permeability=0.999991 conductivity=58000000

design HFSSDesign1 (HFSS, DrivenModal, model units mm)
geometry:
  substrate [PVC plastic] = box(corner=(-17.5mm, -15mm, 0mm), size=(35mm, 30mm, 1mm))
  substrate.move(0mm, 0mm, 0mm)
  Rectangle1 = rectangle(corner=(-17.5mm, -15mm, 0mm), x_size=35mm, y_size=30mm)
  Surface [vacuum] = imported_body()
  S1 = rectangle(corner=(-4mm, 18mm, 1mm), x_size=2.7mm, y_size=0.76mm)
  S1.move(15.35mm, -21.3mm, 0mm)
  S1.move(-0.015mm, 0mm, 0mm)
  S2 = rectangle(corner=(-4mm, 22mm, 0mm), x_size=2.7mm, y_size=0.76mm)
  S2.move(14.9mm, -18.76mm, 0mm)
  S2.move(0.05mm, -0.76mm, 1mm)
  S2.move(0.38mm, 0mm, 0mm)
  S2.move(0.005mm, 0mm, 0mm)
  S3 = rectangle(corner=(-4mm, 25mm, 1mm), x_size=2.7mm, y_size=0.76mm)
  S3.rotate(axis=Z, angle=45deg)
  S3.move(20.5mm, -25mm, 0mm)
  S3.move(0.09mm, 0.06mm, 0mm)
  S3.move(0.01mm, 0mm, 0mm)
  S3.move(0.002mm, 0mm, 0mm)
  S3.move(0.0002mm, 0mm, 0mm)
  S3.move(0.0001mm, 5e-05mm, 0mm)
  S3.move(3e-06mm, 2e-06mm, 0mm)
  S4 = rectangle(corner=(-4mm, 28mm, 1mm), x_size=2.7mm, y_size=0.76mm)
  S4.rotate(axis=Z, angle=135deg)
  S4.move(19.992888mm, 24.679894mm, 0mm)
  S4.move(0.15mm, -0.15mm, 0mm)
  S4.move(0.01mm, -0.005mm, 0mm)
  S4.move(-0.15mm, -13.85mm, 0mm)
  S4.move(0.04mm, -0.04mm, 0mm)
  S4.move(-0.006mm, 0.007mm, 0mm)
  S4.move(0mm, 13.8mm, 0mm)
  S4.rotate(axis=Z, angle=180deg)
  S4.move(2.6mm, -7.8mm, 0mm)
  S4.move(0.02mm, 0.05mm, 0mm)
  S4.move(0mm, 0.015mm, 0mm)
  S4.move(0.02mm, -0.02mm, 0mm)
  S4.move(-0.01mm, 0.02mm, 0mm)
  S4.move(-0.0002mm, 0.0008mm, 0mm)
  S4.move(-1e-05mm, 3e-05mm, 0mm)
  S4.move(-1e-06mm, 1e-06mm, 0mm)
  S4.move(-0.005mm, -0.005mm, 0mm)
  S4.move(0mm, 14mm, 0mm)
  S4.move(0.11424791mm, -0.11908561mm, 0mm)
  G4 = rectangle(corner=(-4mm, 28mm, 1mm), x_size=1.5mm, y_size=0.76mm)
  G4.rotate(axis=Z, angle=135deg)
  G4.move(19.992888mm, 24.679894mm, 0mm)
  G4.move(0.15mm, -0.15mm, 0mm)
  G4.move(0.01mm, -0.005mm, 0mm)
  G4.move(-0.15mm, -13.85mm, 0mm)
  G4.move(0.04mm, -0.04mm, 0mm)
  G4.move(-0.006mm, 0.007mm, 0mm)
  G4.move(0mm, 13.8mm, 0mm)
  G4.rotate(axis=Z, angle=180deg)
  G4.move(2.6mm, -7.8mm, 0mm)
  G4.move(0.02mm, 0.05mm, 0mm)
  G4.move(0mm, 0.015mm, 0mm)
  G4.move(0.02mm, -0.02mm, 0mm)
  G4.move(-0.01mm, 0.02mm, 0mm)
  G4.move(-0.0002mm, 0.0008mm, 0mm)
  G4.move(-1e-05mm, 3e-05mm, 0mm)
  G4.move(-1e-06mm, 1e-06mm, 0mm)
  G4.move(-0.005mm, -0.005mm, 0mm)
  G4.move(0mm, 14mm, 0mm)
  G4.move(0.11424791mm, -0.11908561mm, 0mm)
  G4.move(1.0603952mm, -1.0609252mm, -2.220446e-16mm)
  G4.move(0.84879314mm, -0.84826314mm, 2.220446e-16mm)
  G3 = rectangle(corner=(-4mm, 25mm, 1mm), x_size=1.5mm, y_size=0.76mm)
  G3.rotate(axis=Z, angle=45deg)
  G3.move(20.5mm, -25mm, 0mm)
  G3.move(0.09mm, 0.06mm, 0mm)
  G3.move(0.01mm, 0mm, 0mm)
  G3.move(0.002mm, 0mm, 0mm)
  G3.move(0.0002mm, 0mm, 0mm)
  G3.move(0.0001mm, 5e-05mm, 0mm)
  G3.move(3e-06mm, 2e-06mm, 0mm)
  G3.move(1.9091883mm, 1.9091883mm, 0mm)
  G1 = rectangle(corner=(-4mm, 18mm, 1mm), x_size=1.5mm, y_size=0.76mm)
  G1.move(15.35mm, -21.3mm, 0mm)
  G1.move(-0.015mm, 0mm, 0mm)
  G1.move(2.7mm, 0mm, 0mm)
  G2 = rectangle(corner=(-4mm, 22mm, 0mm), x_size=1.5mm, y_size=0.76mm)
  G2.move(14.9mm, -18.76mm, 0mm)
  G2.move(0.05mm, -0.76mm, 1mm)
  G2.move(0.38mm, 0mm, 0mm)
  G2.move(0.005mm, 0mm, 0mm)
  G2.move(2.7mm, 0mm, 0mm)
  RadiatingSurface [vacuum] = region(absolute_offset=7.6923077mm on all sides)
  Rectangle2 = rectangle(corner=(17.5mm, -1.35mm, 1mm), y_size=2.8mm, z_size=-1mm)
  Ellipse1 = ellipse(normal=Z, centre=(-7mm, -3mm, 1mm), major_radius=10mm, ratio=0.43)
  Ellipse1.move(4mm, 0.5mm, 0mm)
  Ellipse1.move(0mm, 0.1mm, 0mm)
  Surface.unite(Ellipse1)
boundaries and excitations:
  PerfE1: Perfect E Objects=Rectangle1
  Layered1: Layered Impedance Objects=Surface Frequency=0GHz Layers{Layer1{LayerType=1 Thickness=1um Material=copper}}
  Layered2: Layered Impedance Objects=S1 Frequency=0GHz Layers{Layer1{LayerType=1 Thickness=1um Material=copper}}
  Layered3: Layered Impedance Objects=S2 Frequency=0GHz Layers{Layer1{LayerType=1 Thickness=1um Material=copper}}
  Layered4: Layered Impedance Objects=S3 Frequency=0GHz Layers{Layer1{LayerType=1 Thickness=1um Material=copper}}
  Layered5: Layered Impedance Objects=S4 Frequency=0GHz Layers{Layer1{LayerType=1 Thickness=1um Material=copper}}
  Layered10: Layered Impedance Objects=G1 Frequency=0GHz Layers{Layer1{LayerType=1 Thickness=1um Material=graphite}}
  Layered11: Layered Impedance Objects=G2 Frequency=0GHz Layers{Layer1{LayerType=1 Thickness=1um Material=graphite}}
  Layered12: Layered Impedance Objects=G3 Frequency=0GHz Layers{Layer1{LayerType=1 Thickness=1um Material=graphite}}
  Layered13: Layered Impedance Objects=G4 Frequency=0GHz Layers{Layer1{LayerType=1 Thickness=1um Material=graphite}}
  Open1: Radiation Objects=RadiatingSurface
  4: Lumped Port Objects=G4 Modes{Mode1{IntLine{middle of G4.edge(2 of 4) -> middle of G4.edge(4 of 4)} CharImp=Zpi RenormImp=50ohm}} Impedance=20ohm
  3: Lumped Port Objects=G3 Modes{Mode1{IntLine{middle of G3.edge(2 of 4) -> middle of G3.edge(4 of 4)} CharImp=Zpi RenormImp=50ohm}} Impedance=200ohm
  1: Lumped Port Objects=G1 Modes{Mode1{IntLine{middle of G1.edge(x opposite corner) -> middle of G1.edge(x at corner)} CharImp=Zpi RenormImp=50ohm}} Impedance=200ohm
  2: Lumped Port Objects=G2 Modes{Mode1{IntLine{middle of G2.edge(x opposite corner) -> middle of G2.edge(x at corner)} CharImp=Zpi RenormImp=50ohm}} Impedance=20ohm
  5: Lumped Port Objects=Rectangle2 Modes{Mode1{IntLine{Rectangle2.edge(z opposite corner) at 0.518 along -> Rectangle2.edge(z at corner) at 0.482 along} CharImp=Zpi RenormImp=50ohm}} Impedance=50ohm
setups:
  Setup1: HfssDriven MultipleAdaptiveFreqsSetup{Low=7GHz High=18GHz} MaxDeltaS=0.02 MaximumPasses=20 MinimumPasses=1 MinimumConvergedPasses=1 PercentRefinement=30 BasisOrder=1 PortAccuracy=2
    sweep Sweep: 7GHz to 20GHz, 401 points; Type=Fast SaveFields
source amplitudes:
  4:1: 1W 0deg
  3:1, 1:1, 2:1, 5:1: 0W 0deg
radiation setups:
  Infinite Sphere1: Infinite Sphere Theta=0deg..360deg step 2deg Phi=0deg..360deg step 2deg
reports:
  S Parameter Plot 1: dB(S(1,1)) vs Freq on Setup1 : Sweep; markers m1 at 14.4425GHz, m2 at 9.7625GHz, m3 at 8.82GHz, m4 at 7.065GHz, m5 at 11.1925GHz, m6 at 12.1025GHz, m7 at 14.735GHz
  Gain Plot 2: GainTotal vs Phi, Theta on Setup1 : LastAdaptive, Infinite Sphere1 [Freq=12.5GHz]
  Gain Plot 3: dB(GainTotal) vs Phi, Theta on Setup1 : LastAdaptive, Infinite Sphere1 [Freq=12.5GHz]
  Gain Plot 4: dB(GainTotal) vs Theta on Setup1 : Sweep, Infinite Sphere1 [Phi=-180deg,0deg,180deg Freq=7GHz]
